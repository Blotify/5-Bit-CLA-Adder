* NGSPICE file created from and4.ext - technology: scmos

.global Vdd Gnd

* Top level circuit and4

M1000 4NAND C VDD w_0_n1# pfet w=0.72u l=0.18u
+  ad=1.0368p pd=5.76u as=1.5552p ps=10.08u
M1001 VDD D 4NAND w_0_n1# pfet w=0.72u l=0.18u
+  ad=0p pd=0u as=0p ps=0u
M1002 a_33_n36# C a_23_n36# Gnd nfet w=0.36u l=0.18u
+  ad=0.2592p pd=2.16u as=0.2592p ps=2.16u
M1003 a_23_n36# B a_13_n36# Gnd nfet w=0.36u l=0.18u
+  ad=0p pd=0u as=0.2592p ps=2.16u
M1004 4NAND A VDD w_0_n1# pfet w=0.72u l=0.18u
+  ad=0p pd=0u as=0p ps=0u
M1005 OUT 4NAND VDD w_61_n1# pfet w=0.72u l=0.18u
+  ad=0.324p pd=2.34u as=0p ps=0u
M1006 VDD B 4NAND w_0_n1# pfet w=0.72u l=0.18u
+  ad=0p pd=0u as=0p ps=0u
M1007 OUT 4NAND GND Gnd nfet w=0.36u l=0.18u
+  ad=0.162p pd=1.62u as=0.324p ps=3.24u
M1008 a_13_n36# A GND Gnd nfet w=0.36u l=0.18u
+  ad=0p pd=0u as=0p ps=0u
M1009 4NAND D a_33_n36# Gnd nfet w=0.36u l=0.18u
+  ad=0.1944p pd=1.8u as=0p ps=0u
.end

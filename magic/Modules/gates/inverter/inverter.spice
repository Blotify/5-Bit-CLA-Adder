* NGSPICE file created from inverter.ext - technology: scmos

.global Vdd Gnd

* Top level circuit inverter

M1000 out in gnd Gnd nfet w=0.36u l=0.18u
+  ad=0.162p pd=1.62u as=0.162p ps=1.62u
M1001 out in vdd w_n8_n5# pfet w=0.9u l=0.18u
+  ad=0.405p pd=2.7u as=0.405p ps=2.7u
.end
